RC low-pass filter
* Input: 5 V square wave, 1 kHz-ish
V1 in 0 PULSE(0 5 0 1n 1n 0.5m 1m)
R1 in out 1k
C1 out 0 100n

* Simulate 5 ms with 1 us steps
.tran 1u 5m

.control
run
plot v(in) v(out)
.endc

.end
