topico 2, slide 20 - Análise de circuitos 2

Is 0 1 PWL(0 6.4 0.0000001 0)
R1 1 0 10
R2 1 2 6
L1 2 0 0.32
R3 2 0 4

.tran 1ms 1.5s

.control
    run
    plot i(L1)
.endc
.end
