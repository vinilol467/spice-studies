Razavi page 243, exercise 6.47

M1 d g 0 0 meumodelo W = 2u L = 0.18u
Vg g 0 0.9
Ix 0 d DC 0

.model meumodelo nmos (level=1, uo=360, tox=0.4n, vto=0.5, lambda=0.4, +cjo=3e-4, mj=0.35, cjswo=40n, mjswo=0.3)
.dc Ix 0 10m 10u

.control
    run
    plot v(d) xlabel 'Ix (A)' ylabel 'Vx (V)'
.endc
.end
